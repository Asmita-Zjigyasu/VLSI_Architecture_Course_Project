ADE simulation setup
Run mode: Monte Carlo Sampling
Tests:
  vlsi_project:try_cir_10:1: vlsi_project/try_cir_10/schematic, simulator spectre
Global variables:
  f = .57
  h = .58
  k = 180n
  t = 160n
  v = 360n
  x = 240n
  y = 240n
Corners:
  C0: temperature=-40,120
Monte Carlo Sampling options: mcmethod=all, mcnumpoints=50, parasiticanalysis=0
